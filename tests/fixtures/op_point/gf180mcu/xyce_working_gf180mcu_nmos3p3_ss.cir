* TASK-339 fix evidence, `ss` corner -- proves the section-name mapping
* (.LIB ss / res_ss / moscap_ss / ... on the xyce model file) matches the
* ngspice one, not just `typical`. Real Xyce 7.10 run.

.include "$PDK_ROOT/gf180mcuD/libs.tech/xyce/design.xyce"
.lib "$PDK_ROOT/gf180mcuD/libs.tech/xyce/sm141064.xyce" ss
.lib "$PDK_ROOT/gf180mcuD/libs.tech/xyce/sm141064.xyce" res_ss
.lib "$PDK_ROOT/gf180mcuD/libs.tech/xyce/sm141064.xyce" moscap_ss
.lib "$PDK_ROOT/gf180mcuD/libs.tech/xyce/sm141064.xyce" mimcap_ss
.lib "$PDK_ROOT/gf180mcuD/libs.tech/xyce/sm141064.xyce" cap_mim
.lib "$PDK_ROOT/gf180mcuD/libs.tech/xyce/sm141064.xyce" diode_ss
.lib "$PDK_ROOT/gf180mcuD/libs.tech/xyce/sm141064.xyce" bjt_ss

XMM1 vd vg 0 0 nfet_03v3 m=1 w=10u l=0.28u

Vvd vd 0 DC 1.5
Vvg vg 0 DC 1.5

.dc vvd 1.5 1.5 1

.print dc format=raw file=xyce_working_gf180mcu_nmos3p3_ss.raw v(vd) v(vg) N(XMM1:M0:GM) N(XMM1:M0:GDS) N(XMM1:M0:VTH) N(XMM1:M0:VDSAT) N(XMM1:M0:VGS) N(XMM1:M0:VDS) N(XMM1:M0:VBS) ID(XMM1:M0)
.end
