*** Circuit: top.cir
*** Automated netlist generator
*** Generated by silk

*** Including PDK library
.lib "$PDK_ROOT/sky130A/libs.tech/ngspice/sky130.lib.spice" tt
.include "$PDK_ROOT/sky130A/libs.ref/sky130_fd_pr/spice/sky130_fd_pr__cap_vpp_11p5x11p7_m1m2_noshield.model.spice"

*** Defining netlist

*** mm0.  Connections = ['d', 'g', 's', 'b'].
XMmm0 d0 g 0 0 sky130_fd_pr__nfet_01v8 m=1 w=1 l=0.15
*** mm1.  Connections = ['d', 'g', 's', 'b'].
XMmm1 d1 g 0 0 sky130_fd_pr__nfet_01v8 m=1 w=1 l=0.15
*** mm2.  Connections = ['d', 'g', 's', 'b'].
XMmm2 d2 g 0 0 sky130_fd_pr__nfet_01v8 m=1 w=1 l=0.15
*** mm3.  Connections = ['d', 'g', 's', 'b'].
XMmm3 d3 g 0 0 sky130_fd_pr__nfet_01v8 m=1 w=1 l=0.15
*** mm4.  Connections = ['d', 'g', 's', 'b'].
XMmm4 d4 g 0 0 sky130_fd_pr__nfet_01v8 m=1 w=1 l=0.15
*** mm5.  Connections = ['d', 'g', 's', 'b'].
XMmm5 d5 g 0 0 sky130_fd_pr__nfet_01v8 m=1 w=1 l=0.15
*** mm6.  Connections = ['d', 'g', 's', 'b'].
XMmm6 d6 g 0 0 sky130_fd_pr__nfet_01v8 m=1 w=1 l=0.15
*** mm7.  Connections = ['d', 'g', 's', 'b'].
XMmm7 d7 g 0 0 sky130_fd_pr__nfet_01v8 m=1 w=1 l=0.15
*** mm8.  Connections = ['d', 'g', 's', 'b'].
XMmm8 d8 g 0 0 sky130_fd_pr__nfet_01v8 m=1 w=1 l=0.15
*** mm9.  Connections = ['d', 'g', 's', 'b'].
XMmm9 d9 g 0 0 sky130_fd_pr__nfet_01v8 m=1 w=1 l=0.15
*** mm10.  Connections = ['d', 'g', 's', 'b'].
XMmm10 d10 g 0 0 sky130_fd_pr__nfet_01v8 m=1 w=1 l=0.15
*** mm11.  Connections = ['d', 'g', 's', 'b'].
XMmm11 d11 g 0 0 sky130_fd_pr__nfet_01v8 m=1 w=1 l=0.15
*** mm12.  Connections = ['d', 'g', 's', 'b'].
XMmm12 d12 g 0 0 sky130_fd_pr__nfet_01v8 m=1 w=1 l=0.15
*** mm13.  Connections = ['d', 'g', 's', 'b'].
XMmm13 d13 g 0 0 sky130_fd_pr__nfet_01v8 m=1 w=1 l=0.15
*** mm14.  Connections = ['d', 'g', 's', 'b'].
XMmm14 d14 g 0 0 sky130_fd_pr__nfet_01v8 m=1 w=1 l=0.15
*** mm15.  Connections = ['d', 'g', 's', 'b'].
XMmm15 d15 g 0 0 sky130_fd_pr__nfet_01v8 m=1 w=1 l=0.15
*** mm16.  Connections = ['d', 'g', 's', 'b'].
XMmm16 d16 g 0 0 sky130_fd_pr__nfet_01v8 m=1 w=1 l=0.15
*** mm17.  Connections = ['d', 'g', 's', 'b'].
XMmm17 d17 g 0 0 sky130_fd_pr__nfet_01v8 m=1 w=1 l=0.15
*** mm18.  Connections = ['d', 'g', 's', 'b'].
XMmm18 d18 g 0 0 sky130_fd_pr__nfet_01v8 m=1 w=1 l=0.15
*** mm19.  Connections = ['d', 'g', 's', 'b'].
XMmm19 d19 g 0 0 sky130_fd_pr__nfet_01v8 m=1 w=1 l=0.15

*** VoltageSource: vg
Vvg g 0 DC 1
*** VoltageSource: vd0
Vvd0 d0 0 DC 1
*** VoltageSource: vd1
Vvd1 d1 0 DC 1
*** VoltageSource: vd2
Vvd2 d2 0 DC 1
*** VoltageSource: vd3
Vvd3 d3 0 DC 1
*** VoltageSource: vd4
Vvd4 d4 0 DC 1
*** VoltageSource: vd5
Vvd5 d5 0 DC 1
*** VoltageSource: vd6
Vvd6 d6 0 DC 1
*** VoltageSource: vd7
Vvd7 d7 0 DC 1
*** VoltageSource: vd8
Vvd8 d8 0 DC 1
*** VoltageSource: vd9
Vvd9 d9 0 DC 1
*** VoltageSource: vd10
Vvd10 d10 0 DC 1
*** VoltageSource: vd11
Vvd11 d11 0 DC 1
*** VoltageSource: vd12
Vvd12 d12 0 DC 1
*** VoltageSource: vd13
Vvd13 d13 0 DC 1
*** VoltageSource: vd14
Vvd14 d14 0 DC 1
*** VoltageSource: vd15
Vvd15 d15 0 DC 1
*** VoltageSource: vd16
Vvd16 d16 0 DC 1
*** VoltageSource: vd17
Vvd17 d17 0 DC 1
*** VoltageSource: vd18
Vvd18 d18 0 DC 1
*** VoltageSource: vd19
Vvd19 d19 0 DC 1

*** Transient analysis
.tran 10n 10u

.control
save all
run
set wr_singlescale
set wr_vecnames
option numdgt=3
write tran_size_baseline.raw
exit
.endc
.end
