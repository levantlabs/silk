*** Circuit: top.cir
*** Automated netlist generator
*** Generated by silk

*** Including PDK library
.lib "$PDK_ROOT/sky130A/libs.tech/ngspice/sky130.lib.spice" tt
.include "$PDK_ROOT/sky130A/libs.ref/sky130_fd_pr/spice/sky130_fd_pr__cap_vpp_11p5x11p7_m1m2_noshield.model.spice"

*** Device terminal-current ammeter wrappers
.subckt amm_sky130_fd_pr__nfet_01v8 d g s b m=1 w=1 l=0.15
Vamm_d d d_i 0
Vamm_g g g_i 0
Vamm_s s s_i 0
Vamm_b b b_i 0
XMdev d_i g_i s_i b_i sky130_fd_pr__nfet_01v8 m={m} w={w} l={l}
.ends

*** Defining netlist

*** subckt definition for dut
.subckt dut d g s b
*** mm1.  Connections = ['d', 'g', 's', 'b'].
XMmm1 d g s b amm_sky130_fd_pr__nfet_01v8 m=1 w=1 l=0.15
.ends

*** dut.  Connections = ['d', 'g', 's', 'b'].
xdut vd vg vs vs dut

*** VoltageSource: vd
Vvd vd 0 DC 1
*** VoltageSource: vg
Vvg vg 0 DC 1
*** VoltageSource: vs
Vvs vs 0 DC 0

.options savecurrents
*** Transient analysis
.tran 1n 10n

.control
save all
save @m.xdut.xmmm1.xmdev.msky130_fd_pr__nfet_01v8[gm]
op
run
print @m.xdut.xmmm1.xmdev.msky130_fd_pr__nfet_01v8[gm]
write op_probe_ammeter.raw
exit
.endc
.end
