*** Circuit: top.cir
*** Automated netlist generator
*** Generated by silk

*** Including PDK library
.lib "$PDK_ROOT/sky130A/libs.tech/ngspice/sky130.lib.spice" tt
.include "$PDK_ROOT/sky130A/libs.ref/sky130_fd_pr/spice/sky130_fd_pr__cap_vpp_11p5x11p7_m1m2_noshield.model.spice"

*** Defining netlist

*** subckt definition for dut
.subckt dut d g s b
*** mm1.  Connections = ['d', 'g', 's', 'b'].
XMmm1 d g s b sky130_fd_pr__nfet_01v8 m=1 w=1 l=0.15
.ends

*** dut.  Connections = ['d', 'g', 's', 'b'].
xdut vd vg vs vs dut

*** VoltageSource: vd
Vvd vd 0 DC 1
*** VoltageSource: vg
Vvg vg 0 DC 1
*** VoltageSource: vs
Vvs vs 0 DC 0

*** DC analysis
.dc vvd 1 1 1

.options parser scale=1e-6
.print dc format=raw file=xyce_probe_available.raw v(vd) v(vg) v(vs) N(XDUT:XMMM1:MSKY130_FD_PR__NFET_01V8:GM) N(XDUT:XMMM1:MSKY130_FD_PR__NFET_01V8:GDS) N(XDUT:XMMM1:MSKY130_FD_PR__NFET_01V8:VTH) N(XDUT:XMMM1:MSKY130_FD_PR__NFET_01V8:VDSAT) N(XDUT:XMMM1:MSKY130_FD_PR__NFET_01V8:VGS) N(XDUT:XMMM1:MSKY130_FD_PR__NFET_01V8:VDS) N(XDUT:XMMM1:MSKY130_FD_PR__NFET_01V8:VBS) ID(XDUT:XMMM1:MSKY130_FD_PR__NFET_01V8)
.end
