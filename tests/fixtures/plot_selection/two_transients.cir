Two transient runs saved together
Vbias out 0 DC 1
Rload out 0 1k
.control
set filetype=ascii
tran 1u 10u
alter Vbias dc=9
tran 1u 10u
setplot
print tran1.v(out)[0] tran2.v(out)[0]
write combined.raw tran1.all tran2.all
write reversed.raw tran2.all tran1.all
quit 0
.endc
.end
