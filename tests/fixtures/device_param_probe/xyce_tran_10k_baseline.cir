*** TASK-330.8 AC#1 spike: Xyce 10k-point .tran cost, device-param probing.
*** 20 flat NMOS instances (mirrors tests/fixtures/op_point/tran_size_*.sp's
*** ngspice topology), XYCE_OP_CAPABILITY columns only (Xyce doesn't expose
*** gmbs/caps -- TASK-330.1/330.5 finding).

.lib "$PDK_ROOT/sky130A/libs.tech/ngspice/sky130.lib.spice" tt
.include "$PDK_ROOT/sky130A/libs.ref/sky130_fd_pr/spice/sky130_fd_pr__cap_vpp_11p5x11p7_m1m2_noshield.model.spice"

XMmm0 d0 g 0 0 sky130_fd_pr__nfet_01v8 m=1 w=1 l=0.15
XMmm1 d1 g 0 0 sky130_fd_pr__nfet_01v8 m=1 w=1 l=0.15
XMmm2 d2 g 0 0 sky130_fd_pr__nfet_01v8 m=1 w=1 l=0.15
XMmm3 d3 g 0 0 sky130_fd_pr__nfet_01v8 m=1 w=1 l=0.15
XMmm4 d4 g 0 0 sky130_fd_pr__nfet_01v8 m=1 w=1 l=0.15
XMmm5 d5 g 0 0 sky130_fd_pr__nfet_01v8 m=1 w=1 l=0.15
XMmm6 d6 g 0 0 sky130_fd_pr__nfet_01v8 m=1 w=1 l=0.15
XMmm7 d7 g 0 0 sky130_fd_pr__nfet_01v8 m=1 w=1 l=0.15
XMmm8 d8 g 0 0 sky130_fd_pr__nfet_01v8 m=1 w=1 l=0.15
XMmm9 d9 g 0 0 sky130_fd_pr__nfet_01v8 m=1 w=1 l=0.15
XMmm10 d10 g 0 0 sky130_fd_pr__nfet_01v8 m=1 w=1 l=0.15
XMmm11 d11 g 0 0 sky130_fd_pr__nfet_01v8 m=1 w=1 l=0.15
XMmm12 d12 g 0 0 sky130_fd_pr__nfet_01v8 m=1 w=1 l=0.15
XMmm13 d13 g 0 0 sky130_fd_pr__nfet_01v8 m=1 w=1 l=0.15
XMmm14 d14 g 0 0 sky130_fd_pr__nfet_01v8 m=1 w=1 l=0.15
XMmm15 d15 g 0 0 sky130_fd_pr__nfet_01v8 m=1 w=1 l=0.15
XMmm16 d16 g 0 0 sky130_fd_pr__nfet_01v8 m=1 w=1 l=0.15
XMmm17 d17 g 0 0 sky130_fd_pr__nfet_01v8 m=1 w=1 l=0.15
XMmm18 d18 g 0 0 sky130_fd_pr__nfet_01v8 m=1 w=1 l=0.15
XMmm19 d19 g 0 0 sky130_fd_pr__nfet_01v8 m=1 w=1 l=0.15

Vvg g 0 DC 1
Vvd0 d0 0 DC 1
Vvd1 d1 0 DC 1
Vvd2 d2 0 DC 1
Vvd3 d3 0 DC 1
Vvd4 d4 0 DC 1
Vvd5 d5 0 DC 1
Vvd6 d6 0 DC 1
Vvd7 d7 0 DC 1
Vvd8 d8 0 DC 1
Vvd9 d9 0 DC 1
Vvd10 d10 0 DC 1
Vvd11 d11 0 DC 1
Vvd12 d12 0 DC 1
Vvd13 d13 0 DC 1
Vvd14 d14 0 DC 1
Vvd15 d15 0 DC 1
Vvd16 d16 0 DC 1
Vvd17 d17 0 DC 1
Vvd18 d18 0 DC 1
Vvd19 d19 0 DC 1

.tran 10n 100u 0 10n

.options parser scale=1e-6
.print tran format=raw file=xyce_tran_10k_baseline.raw v(d0) v(g)
.end
