*** Circuit: test_dut~probechk.cir
*** Automated netlist generator
*** Generated by silk

*** Including PDK library
.lib "<pdk_root>/sky130A/libs.tech/ngspice/sky130.lib.spice" tt
.include "<pdk_root>/sky130A/libs.ref/sky130_fd_pr/spice/sky130_fd_pr__cap_vpp_11p5x11p7_m1m2_noshield.model.spice"

*** Defining netlist

*** subckt definition for dut
.subckt dut d g s b data3 busen
*** M1.  Connections = ['d', 'g', 's', 'b'].
XMM1 d g s b sky130_fd_pr__nfet_01v8 m=1 w=1 l=0.15
.ends

*** dut.  Connections = ['d', 'g', 's', 'b', 'data3', 'busen'].
xdut vd vg 0 0 data[3] bus[1] dut

*** VoltageSource: vd
Vvd vd 0 DC 1
*** VoltageSource: vg
Vvg vg 0 DC 1

*** Transient analysis
.tran 1n 5n

.control
save all
run
set wr_singlescale
set wr_vecnames
option numdgt=3
write <tmpdir>
quit 0
.endc
.end
