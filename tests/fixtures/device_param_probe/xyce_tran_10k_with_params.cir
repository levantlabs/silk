*** TASK-330.8 AC#1 spike: Xyce 10k-point .tran cost, device-param probing.
*** 20 flat NMOS instances (mirrors tests/fixtures/op_point/tran_size_*.sp's
*** ngspice topology), XYCE_OP_CAPABILITY columns only (Xyce doesn't expose
*** gmbs/caps -- TASK-330.1/330.5 finding).

.lib "$PDK_ROOT/sky130A/libs.tech/ngspice/sky130.lib.spice" tt
.include "$PDK_ROOT/sky130A/libs.ref/sky130_fd_pr/spice/sky130_fd_pr__cap_vpp_11p5x11p7_m1m2_noshield.model.spice"

XMmm0 d0 g 0 0 sky130_fd_pr__nfet_01v8 m=1 w=1 l=0.15
XMmm1 d1 g 0 0 sky130_fd_pr__nfet_01v8 m=1 w=1 l=0.15
XMmm2 d2 g 0 0 sky130_fd_pr__nfet_01v8 m=1 w=1 l=0.15
XMmm3 d3 g 0 0 sky130_fd_pr__nfet_01v8 m=1 w=1 l=0.15
XMmm4 d4 g 0 0 sky130_fd_pr__nfet_01v8 m=1 w=1 l=0.15
XMmm5 d5 g 0 0 sky130_fd_pr__nfet_01v8 m=1 w=1 l=0.15
XMmm6 d6 g 0 0 sky130_fd_pr__nfet_01v8 m=1 w=1 l=0.15
XMmm7 d7 g 0 0 sky130_fd_pr__nfet_01v8 m=1 w=1 l=0.15
XMmm8 d8 g 0 0 sky130_fd_pr__nfet_01v8 m=1 w=1 l=0.15
XMmm9 d9 g 0 0 sky130_fd_pr__nfet_01v8 m=1 w=1 l=0.15
XMmm10 d10 g 0 0 sky130_fd_pr__nfet_01v8 m=1 w=1 l=0.15
XMmm11 d11 g 0 0 sky130_fd_pr__nfet_01v8 m=1 w=1 l=0.15
XMmm12 d12 g 0 0 sky130_fd_pr__nfet_01v8 m=1 w=1 l=0.15
XMmm13 d13 g 0 0 sky130_fd_pr__nfet_01v8 m=1 w=1 l=0.15
XMmm14 d14 g 0 0 sky130_fd_pr__nfet_01v8 m=1 w=1 l=0.15
XMmm15 d15 g 0 0 sky130_fd_pr__nfet_01v8 m=1 w=1 l=0.15
XMmm16 d16 g 0 0 sky130_fd_pr__nfet_01v8 m=1 w=1 l=0.15
XMmm17 d17 g 0 0 sky130_fd_pr__nfet_01v8 m=1 w=1 l=0.15
XMmm18 d18 g 0 0 sky130_fd_pr__nfet_01v8 m=1 w=1 l=0.15
XMmm19 d19 g 0 0 sky130_fd_pr__nfet_01v8 m=1 w=1 l=0.15

Vvg g 0 DC 1
Vvd0 d0 0 DC 1
Vvd1 d1 0 DC 1
Vvd2 d2 0 DC 1
Vvd3 d3 0 DC 1
Vvd4 d4 0 DC 1
Vvd5 d5 0 DC 1
Vvd6 d6 0 DC 1
Vvd7 d7 0 DC 1
Vvd8 d8 0 DC 1
Vvd9 d9 0 DC 1
Vvd10 d10 0 DC 1
Vvd11 d11 0 DC 1
Vvd12 d12 0 DC 1
Vvd13 d13 0 DC 1
Vvd14 d14 0 DC 1
Vvd15 d15 0 DC 1
Vvd16 d16 0 DC 1
Vvd17 d17 0 DC 1
Vvd18 d18 0 DC 1
Vvd19 d19 0 DC 1

.tran 10n 100u 0 10n

.options parser scale=1e-6
.print tran format=raw file=xyce_tran_10k_with_params.raw v(d0) v(g) N(XMMM0:MSKY130_FD_PR__NFET_01V8:GM) N(XMMM0:MSKY130_FD_PR__NFET_01V8:GDS) N(XMMM0:MSKY130_FD_PR__NFET_01V8:VTH) N(XMMM0:MSKY130_FD_PR__NFET_01V8:VDSAT) N(XMMM0:MSKY130_FD_PR__NFET_01V8:VGS) N(XMMM0:MSKY130_FD_PR__NFET_01V8:VDS) N(XMMM0:MSKY130_FD_PR__NFET_01V8:VBS) ID(XMMM0:MSKY130_FD_PR__NFET_01V8) N(XMMM1:MSKY130_FD_PR__NFET_01V8:GM) N(XMMM1:MSKY130_FD_PR__NFET_01V8:GDS) N(XMMM1:MSKY130_FD_PR__NFET_01V8:VTH) N(XMMM1:MSKY130_FD_PR__NFET_01V8:VDSAT) N(XMMM1:MSKY130_FD_PR__NFET_01V8:VGS) N(XMMM1:MSKY130_FD_PR__NFET_01V8:VDS) N(XMMM1:MSKY130_FD_PR__NFET_01V8:VBS) ID(XMMM1:MSKY130_FD_PR__NFET_01V8) N(XMMM2:MSKY130_FD_PR__NFET_01V8:GM) N(XMMM2:MSKY130_FD_PR__NFET_01V8:GDS) N(XMMM2:MSKY130_FD_PR__NFET_01V8:VTH) N(XMMM2:MSKY130_FD_PR__NFET_01V8:VDSAT) N(XMMM2:MSKY130_FD_PR__NFET_01V8:VGS) N(XMMM2:MSKY130_FD_PR__NFET_01V8:VDS) N(XMMM2:MSKY130_FD_PR__NFET_01V8:VBS) ID(XMMM2:MSKY130_FD_PR__NFET_01V8) N(XMMM3:MSKY130_FD_PR__NFET_01V8:GM) N(XMMM3:MSKY130_FD_PR__NFET_01V8:GDS) N(XMMM3:MSKY130_FD_PR__NFET_01V8:VTH) N(XMMM3:MSKY130_FD_PR__NFET_01V8:VDSAT) N(XMMM3:MSKY130_FD_PR__NFET_01V8:VGS) N(XMMM3:MSKY130_FD_PR__NFET_01V8:VDS) N(XMMM3:MSKY130_FD_PR__NFET_01V8:VBS) ID(XMMM3:MSKY130_FD_PR__NFET_01V8) N(XMMM4:MSKY130_FD_PR__NFET_01V8:GM) N(XMMM4:MSKY130_FD_PR__NFET_01V8:GDS) N(XMMM4:MSKY130_FD_PR__NFET_01V8:VTH) N(XMMM4:MSKY130_FD_PR__NFET_01V8:VDSAT) N(XMMM4:MSKY130_FD_PR__NFET_01V8:VGS) N(XMMM4:MSKY130_FD_PR__NFET_01V8:VDS) N(XMMM4:MSKY130_FD_PR__NFET_01V8:VBS) ID(XMMM4:MSKY130_FD_PR__NFET_01V8) N(XMMM5:MSKY130_FD_PR__NFET_01V8:GM) N(XMMM5:MSKY130_FD_PR__NFET_01V8:GDS) N(XMMM5:MSKY130_FD_PR__NFET_01V8:VTH) N(XMMM5:MSKY130_FD_PR__NFET_01V8:VDSAT) N(XMMM5:MSKY130_FD_PR__NFET_01V8:VGS) N(XMMM5:MSKY130_FD_PR__NFET_01V8:VDS) N(XMMM5:MSKY130_FD_PR__NFET_01V8:VBS) ID(XMMM5:MSKY130_FD_PR__NFET_01V8) N(XMMM6:MSKY130_FD_PR__NFET_01V8:GM) N(XMMM6:MSKY130_FD_PR__NFET_01V8:GDS) N(XMMM6:MSKY130_FD_PR__NFET_01V8:VTH) N(XMMM6:MSKY130_FD_PR__NFET_01V8:VDSAT) N(XMMM6:MSKY130_FD_PR__NFET_01V8:VGS) N(XMMM6:MSKY130_FD_PR__NFET_01V8:VDS) N(XMMM6:MSKY130_FD_PR__NFET_01V8:VBS) ID(XMMM6:MSKY130_FD_PR__NFET_01V8) N(XMMM7:MSKY130_FD_PR__NFET_01V8:GM) N(XMMM7:MSKY130_FD_PR__NFET_01V8:GDS) N(XMMM7:MSKY130_FD_PR__NFET_01V8:VTH) N(XMMM7:MSKY130_FD_PR__NFET_01V8:VDSAT) N(XMMM7:MSKY130_FD_PR__NFET_01V8:VGS) N(XMMM7:MSKY130_FD_PR__NFET_01V8:VDS) N(XMMM7:MSKY130_FD_PR__NFET_01V8:VBS) ID(XMMM7:MSKY130_FD_PR__NFET_01V8) N(XMMM8:MSKY130_FD_PR__NFET_01V8:GM) N(XMMM8:MSKY130_FD_PR__NFET_01V8:GDS) N(XMMM8:MSKY130_FD_PR__NFET_01V8:VTH) N(XMMM8:MSKY130_FD_PR__NFET_01V8:VDSAT) N(XMMM8:MSKY130_FD_PR__NFET_01V8:VGS) N(XMMM8:MSKY130_FD_PR__NFET_01V8:VDS) N(XMMM8:MSKY130_FD_PR__NFET_01V8:VBS) ID(XMMM8:MSKY130_FD_PR__NFET_01V8) N(XMMM9:MSKY130_FD_PR__NFET_01V8:GM) N(XMMM9:MSKY130_FD_PR__NFET_01V8:GDS) N(XMMM9:MSKY130_FD_PR__NFET_01V8:VTH) N(XMMM9:MSKY130_FD_PR__NFET_01V8:VDSAT) N(XMMM9:MSKY130_FD_PR__NFET_01V8:VGS) N(XMMM9:MSKY130_FD_PR__NFET_01V8:VDS) N(XMMM9:MSKY130_FD_PR__NFET_01V8:VBS) ID(XMMM9:MSKY130_FD_PR__NFET_01V8) N(XMMM10:MSKY130_FD_PR__NFET_01V8:GM) N(XMMM10:MSKY130_FD_PR__NFET_01V8:GDS) N(XMMM10:MSKY130_FD_PR__NFET_01V8:VTH) N(XMMM10:MSKY130_FD_PR__NFET_01V8:VDSAT) N(XMMM10:MSKY130_FD_PR__NFET_01V8:VGS) N(XMMM10:MSKY130_FD_PR__NFET_01V8:VDS) N(XMMM10:MSKY130_FD_PR__NFET_01V8:VBS) ID(XMMM10:MSKY130_FD_PR__NFET_01V8) N(XMMM11:MSKY130_FD_PR__NFET_01V8:GM) N(XMMM11:MSKY130_FD_PR__NFET_01V8:GDS) N(XMMM11:MSKY130_FD_PR__NFET_01V8:VTH) N(XMMM11:MSKY130_FD_PR__NFET_01V8:VDSAT) N(XMMM11:MSKY130_FD_PR__NFET_01V8:VGS) N(XMMM11:MSKY130_FD_PR__NFET_01V8:VDS) N(XMMM11:MSKY130_FD_PR__NFET_01V8:VBS) ID(XMMM11:MSKY130_FD_PR__NFET_01V8) N(XMMM12:MSKY130_FD_PR__NFET_01V8:GM) N(XMMM12:MSKY130_FD_PR__NFET_01V8:GDS) N(XMMM12:MSKY130_FD_PR__NFET_01V8:VTH) N(XMMM12:MSKY130_FD_PR__NFET_01V8:VDSAT) N(XMMM12:MSKY130_FD_PR__NFET_01V8:VGS) N(XMMM12:MSKY130_FD_PR__NFET_01V8:VDS) N(XMMM12:MSKY130_FD_PR__NFET_01V8:VBS) ID(XMMM12:MSKY130_FD_PR__NFET_01V8) N(XMMM13:MSKY130_FD_PR__NFET_01V8:GM) N(XMMM13:MSKY130_FD_PR__NFET_01V8:GDS) N(XMMM13:MSKY130_FD_PR__NFET_01V8:VTH) N(XMMM13:MSKY130_FD_PR__NFET_01V8:VDSAT) N(XMMM13:MSKY130_FD_PR__NFET_01V8:VGS) N(XMMM13:MSKY130_FD_PR__NFET_01V8:VDS) N(XMMM13:MSKY130_FD_PR__NFET_01V8:VBS) ID(XMMM13:MSKY130_FD_PR__NFET_01V8) N(XMMM14:MSKY130_FD_PR__NFET_01V8:GM) N(XMMM14:MSKY130_FD_PR__NFET_01V8:GDS) N(XMMM14:MSKY130_FD_PR__NFET_01V8:VTH) N(XMMM14:MSKY130_FD_PR__NFET_01V8:VDSAT) N(XMMM14:MSKY130_FD_PR__NFET_01V8:VGS) N(XMMM14:MSKY130_FD_PR__NFET_01V8:VDS) N(XMMM14:MSKY130_FD_PR__NFET_01V8:VBS) ID(XMMM14:MSKY130_FD_PR__NFET_01V8) N(XMMM15:MSKY130_FD_PR__NFET_01V8:GM) N(XMMM15:MSKY130_FD_PR__NFET_01V8:GDS) N(XMMM15:MSKY130_FD_PR__NFET_01V8:VTH) N(XMMM15:MSKY130_FD_PR__NFET_01V8:VDSAT) N(XMMM15:MSKY130_FD_PR__NFET_01V8:VGS) N(XMMM15:MSKY130_FD_PR__NFET_01V8:VDS) N(XMMM15:MSKY130_FD_PR__NFET_01V8:VBS) ID(XMMM15:MSKY130_FD_PR__NFET_01V8) N(XMMM16:MSKY130_FD_PR__NFET_01V8:GM) N(XMMM16:MSKY130_FD_PR__NFET_01V8:GDS) N(XMMM16:MSKY130_FD_PR__NFET_01V8:VTH) N(XMMM16:MSKY130_FD_PR__NFET_01V8:VDSAT) N(XMMM16:MSKY130_FD_PR__NFET_01V8:VGS) N(XMMM16:MSKY130_FD_PR__NFET_01V8:VDS) N(XMMM16:MSKY130_FD_PR__NFET_01V8:VBS) ID(XMMM16:MSKY130_FD_PR__NFET_01V8) N(XMMM17:MSKY130_FD_PR__NFET_01V8:GM) N(XMMM17:MSKY130_FD_PR__NFET_01V8:GDS) N(XMMM17:MSKY130_FD_PR__NFET_01V8:VTH) N(XMMM17:MSKY130_FD_PR__NFET_01V8:VDSAT) N(XMMM17:MSKY130_FD_PR__NFET_01V8:VGS) N(XMMM17:MSKY130_FD_PR__NFET_01V8:VDS) N(XMMM17:MSKY130_FD_PR__NFET_01V8:VBS) ID(XMMM17:MSKY130_FD_PR__NFET_01V8) N(XMMM18:MSKY130_FD_PR__NFET_01V8:GM) N(XMMM18:MSKY130_FD_PR__NFET_01V8:GDS) N(XMMM18:MSKY130_FD_PR__NFET_01V8:VTH) N(XMMM18:MSKY130_FD_PR__NFET_01V8:VDSAT) N(XMMM18:MSKY130_FD_PR__NFET_01V8:VGS) N(XMMM18:MSKY130_FD_PR__NFET_01V8:VDS) N(XMMM18:MSKY130_FD_PR__NFET_01V8:VBS) ID(XMMM18:MSKY130_FD_PR__NFET_01V8) N(XMMM19:MSKY130_FD_PR__NFET_01V8:GM) N(XMMM19:MSKY130_FD_PR__NFET_01V8:GDS) N(XMMM19:MSKY130_FD_PR__NFET_01V8:VTH) N(XMMM19:MSKY130_FD_PR__NFET_01V8:VDSAT) N(XMMM19:MSKY130_FD_PR__NFET_01V8:VGS) N(XMMM19:MSKY130_FD_PR__NFET_01V8:VDS) N(XMMM19:MSKY130_FD_PR__NFET_01V8:VBS) ID(XMMM19:MSKY130_FD_PR__NFET_01V8)
.end
