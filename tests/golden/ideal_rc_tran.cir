*** Circuit: rc.cir
*** Automated netlist generator
*** Generated by silk

*** No PDK library included: this deck instantiates no PDK
*** device (ideal elements, passives and sources only), so it
*** runs with no PDK installed. One PDK device anywhere in
*** the hierarchy, or any add_custom_line() text, restores it.

*** Defining netlist

*** r1.  Connections = ['p', 'n'].
Rr1 vin vout 1k
*** c1.  Connections = ['p', 'n'].
Cc1 vout 0 1p

*** VoltageSource: vin
Vvin__silk_wave vin __silk_src_Vvin PULSE(0 1.0 1e-09 1e-10 1e-10 5e-09 1e-08)
Vvin__silk_dc __silk_src_Vvin 0 DC 0

*** Transient analysis
.tran 10p 20n

.control
save all
run
set wr_singlescale
set wr_vecnames
option numdgt=3
write <DIR>/rawfile.raw
quit 0
.endc
.end
