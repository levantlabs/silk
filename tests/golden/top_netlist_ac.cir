*** Circuit: top_fixture.cir
*** Automated netlist generator
*** Generated by silk

*** Including PDK library
.lib "/PDK/sky130.lib.spice" tt

*** Defining netlist

*** M1.  Connections = ['d', 'g', 's', 'b'].
XMM1 vout vdd 0 0 sky130_fd_pr__nfet_01v8 m=1 w=1 l=0.15

*** VoltageSource: vdd
Vvdd vdd 0 DC 1.8
*** VoltageSource: vin
Vvin vout 0 DC 0.9 AC 1

*** AC analysis
.ac dec 10 1 1G

.control
save all
run
set wr_singlescale
set wr_vecnames
option numdgt=3
write <DIR>/rawfile.raw
quit 0
.endc
.end
